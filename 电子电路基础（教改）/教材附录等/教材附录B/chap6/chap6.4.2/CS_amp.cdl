**************************************************
* 　　模拟电路基础——从系统级到电路级             *
**************************************************
* 　　　　　陈抗生　周金芳                       *
**************************************************
* 　　　　 科学出版社　2020                      *
**************************************************

.SUBCKT CS_AMP GNDA VDDA vin vout Vbias

* with current-source load
MM1 vout vin	 GNDA GNDA n18	W=10u	L=180n	M=1
MM2 vout Vbias VDDA VDDA p18	W=60u	L=1u	M=1

.ENDS
